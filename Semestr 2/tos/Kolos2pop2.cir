Kolos2pop2

.LIB "EVAL_TOS.LIB"

Xzener 0 2 ZENER_II
Xtrans IN1 IN2 OUT1 OUT2 TX_II

D1 OUT1 1 D1N4148
D2 0 OUT2 D1N4148
D3 OUT2 1 D1N4148
D4 0 OUT1 D1N4148

C1 1 0 {c}
.PARAM c = 500u
.STEP PARAM c 5.1m 10m 0.1m

R1 1 2 200
RL 0 2 1k
Rb 0 IN2 1f

V1 IN1 0 SIN 0 120 60

.TRAN 0 1.05 1 10u
.PROBE
.END
*c = 7.2m
