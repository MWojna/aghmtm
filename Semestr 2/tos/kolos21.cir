Kolos 2

.LIB "EVAL_TOS.LIB"

Xzener 0 2 ZENER_II
Xtrans IN1 0 OUT1 OUT2 TX_II

V1 3 0 SIN 0 120 60
Rin 3 IN1 1f

D1 OUT1 1 D1N4148
D2 0 OUT2 D1N4148
D3 OUT2 1 D1N4148
D4 0 OUT1 D1N4148

C1 1 0 {c}

R1 1 2 200
RL 2 0 1k

.PARAM c = 6.4m
*.PARAM c = 500u
*.STEP PARAM c 6m 7m 0.1m
.TRAN 1m 5.1 5 100u
.PROBE
.END
