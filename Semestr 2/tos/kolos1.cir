Kolos 2

R1 1 2 1k
R2 1 3 2k
R3 3 0 3k

C1 3 0 1u
C2 1 3 2u
C3 1 0 3u

V1 2 0 AC 1
.OP
.AC DEC 1k 1 1k
.TRAN 0 1 0 1u
.PROBE V(2) V(3)
.END

*in - 2
*out - 3
