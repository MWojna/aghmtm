Kolos2A

.LIB "EVAL_TOS.LIB"

Xtrans IN1 0 OUT1 0 OUT3 TX_I
Xzener 0 2 ZENER_I

V1 3 0 SIN 0 120 60
Rv 3 IN1 1f

R1 1 2 191
RL 2 0 150

C1 1 0 {c}
*.PARAM c = 520u
.PARAM c = 13.5m
*.STEP PARAM c 13m 14m 0.1m

D1 OUT1 1 D1N4148
D2 OUT3 1 D1N4148

.TRAN 0 10.1 10 100u
.PROBE
.END
