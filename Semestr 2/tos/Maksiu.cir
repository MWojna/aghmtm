Maksiu

R1 1 0 39
R2 0 5 18
R3 3 4 72

I1 4 0 DC 0.6
V1 1 2 DC 10
H1 2 3 VA 40

VA 2 5 DC 0

Ith 0 3 1

.OP
.DC V1 10 10 1
.PRINT DC V(1,3) V(0,3)
.TF V(3) Ith
.END
